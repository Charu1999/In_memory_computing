// Design: sram_6t/sram_cell_8t_noise_margin
simulator lang=spectre
global 0
parameters x=0
include "/home/ecegrid/a/559mg23/vlsi_assignment/sram_6t/tsmc18dN.m"
include "/home/ecegrid/a/559mg23/vlsi_assignment/sram_6t/tsmc18dP.m"

// sram_6t/sram_cell_8t_noise_margin/schematic
N6 (RBL RWL net1 GND) tsmc18dN w=270.0n l=180.0n m=1 region=sat
N5 (net1 QB GND GND) tsmc18dN w=270.0n l=180.0n m=1 region=sat
N4 (WBLB WWL QB GND) tsmc18dN w=540.0n l=180.0n m=1 region=sat
N2 (QB Q GND GND) tsmc18dN w=270.0n l=180.0n m=1 region=sat
P0 (QB Q VDD VDD) tsmc18dP w=270.0n l=180.0n m=1 region=sat
C2 (WWL GND) capacitor c=1p m=1
C1 (WBLB GND) capacitor c=1p m=1
C3 (RBL GND) capacitor c=1p m=1
V0 (Q GND) vsource type=dc dc=x
include "./_graphical_stimuli.scs"
simulatorOptions options temp=27
dcOp dc
dc dc param=x start=0 stop=1.8
save Q QB
