_vBLB (BLB 0) vsource dc=1.8 type=dc
_vBL (BL 0) vsource dc=0 type=dc
_vWL (WL 0) vsource val0=0 val1=1.8 period=100n delay=1n rise=1n fall=1n width=5n type=pulse
_vGND (GND 0) vsource dc=0 type=dc
_vVDD (VDD 0) vsource dc=1.8 type=dc
