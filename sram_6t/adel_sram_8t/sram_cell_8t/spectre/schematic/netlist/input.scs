// Design: sram_6t/sram_cell_8t
simulator lang=spectre
global 0
include "/home/ecegrid/a/559mg23/vlsi_assignment/sram_6t/tsmc18dN.m"
include "/home/ecegrid/a/559mg23/vlsi_assignment/sram_6t/tsmc18dP.m"

// sram_6t/sram_cell_8t/schematic
N6 (RBL RWL net1 GND) tsmc18dN w=270.0n l=180.0n m=1 region=sat
N5 (net1 QB GND GND) tsmc18dN w=270.0n l=180.0n m=1 region=sat
N4 (WBLB WWL QB GND) tsmc18dN w=270.0n l=180.0n m=1 region=sat
N3 (Q WWL WBL GND) tsmc18dN w=270.0n l=180.0n m=1 region=sat
N2 (QB Q GND GND) tsmc18dN w=270.0n l=180.0n m=1 region=sat
N1 (GND QB Q GND) tsmc18dN w=270.0n l=180.0n m=1 region=sat
P1 (Q QB VDD VDD) tsmc18dP w=540.0n l=180.0n m=1 region=sat
P0 (QB Q VDD VDD) tsmc18dP w=540.0n l=180.0n m=1 region=sat
C3 (RBL GND) capacitor c=1p m=1
C2 (WWL GND) capacitor c=1p m=1
C1 (WBLB GND) capacitor c=1p m=1
C0 (WBL GND) capacitor c=1p m=1
include "./_graphical_stimuli.scs"
ic RBL=1.8 QB=1.8 Q=0
simulatorOptions options temp=27
tran tran stop=100n
