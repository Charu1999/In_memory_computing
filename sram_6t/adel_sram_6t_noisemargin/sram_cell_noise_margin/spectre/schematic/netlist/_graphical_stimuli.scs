_vBLB (BLB 0) vsource dc=1.8 val0=0 val1=1.8 period=2u type=pulse
_vBL (BL 0) vsource dc=1.8 val0=0 val1=1.8 period=2u type=pulse
_vWL (WL 0) vsource dc=1.8 val0=0 val1=1.8 period=4u type=pulse
_vGND (GND 0) vsource dc=0 type=dc
_vVDD (VDD 0) vsource dc=1.8 type=dc
