// Design: sram_6t/sram_cell_8t_ckt_layout_simulation_noise_margin
simulator lang=spectre
global 0
parameters x=0
include "/home/ecegrid/a/559mg23/vlsi_assignment/sram_6t/tsmc18dN.m"
include "/home/ecegrid/a/559mg23/vlsi_assignment/sram_6t/tsmc18dP.m"

// sram_6t/sram_cell_8t_ckt_layout/schematic
subckt sram_cell_8t_ckt_layout GND Q QB RBL RWL VDD WBL WBLB WWL
    N6 (RBL RWL net1 GND) tsmc18dN w=270.0n l=180.0n m=1 region=sat
    N5 (net1 Q GND GND) tsmc18dN w=270.0n l=180.0n m=1 region=sat
    N4 (WBLB WWL QB GND) tsmc18dN w=540.0n l=180.0n m=1 region=sat
    N3 (Q WWL WBL GND) tsmc18dN w=540.0n l=180.0n m=1 region=sat
    N2 (QB Q GND GND) tsmc18dN w=270.0n l=180.0n m=1 region=sat
    N1 (GND QB Q GND) tsmc18dN w=270.0n l=180.0n m=1 region=sat
    P1 (Q QB VDD VDD) tsmc18dP w=270.0n l=180.0n m=1 region=sat
    P0 (QB Q VDD VDD) tsmc18dP w=270.0n l=180.0n m=1 region=sat
ends sram_cell_8t_ckt_layout

// sram_6t/sram_cell_8t_ckt_layout_simulation_noise_margin/schematic
C2 (WBL GND) capacitor c=10p m=1
C0 (WBLB GND) capacitor c=10p m=1
C1 (RBL GND) capacitor c=10p m=1
C4 (RWL GND) capacitor c=10p m=1
C3 (WWL GND) capacitor c=10p m=1
I0 (GND Q QB RBL RWL VDD WBL WBLB WWL) sram_cell_8t_ckt_layout
V0 (Q GND) vsource type=dc dc=x
include "./_graphical_stimuli.scs"
simulatorOptions options temp=27
dcOp dc
dc dc param=x start=0 stop=1.8
