// Design: sram_6t/sram_cell
simulator lang=spectre
global 0
parameters _gpar0
include "/home/ecegrid/a/559mg23/vlsi_assignment/sram_6t/tsmc18dN.m"
include "/home/ecegrid/a/559mg23/vlsi_assignment/sram_6t/tsmc18dP.m"

// sram_6t/sram_cell/schematic
N3 (Q WL BL GND) tsmc18dN w=315.00n l=180.0n m=1 region=sat
N1 (GND QB Q GND) tsmc18dN w=405.00n l=180.0n m=1 region=sat
N4 (BLB WL QB GND) tsmc18dN w=315.00n l=180.0n m=1 region=sat
N2 (QB Q GND GND) tsmc18dN w=405.00n l=180.0n m=1 region=sat
P1 (Q QB VDD VDD) tsmc18dP w=270.0n l=180.0n m=1 region=sat
P0 (QB Q VDD VDD) tsmc18dP w=270.0n l=180.0n m=1 region=sat
C2 (WL GND) capacitor c=1p m=1
C1 (BLB GND) capacitor c=1p m=1
C0 (BL GND) capacitor c=1p m=1
include "./_graphical_stimuli.scs"
simulatorOptions options temp=27
dc dc
save BL BLB WL Q QB
