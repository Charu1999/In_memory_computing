_vWBLB (WBLB 0) vsource dc=1.8 type=dc
_vRBL (RBL 0) vsource dc=0 type=dc
_vRWL (RWL 0) vsource dc=0 type=dc
_vWWL (WWL 0) vsource wave=[ 0n 0 10n 0 10.5n 1.8 11n 1.8 11.5n 0 ] type=pwl
_vWBL (WBL 0) vsource dc=0 type=dc
_vGND (GND 0) vsource dc=0 type=dc
_vVDD (VDD 0) vsource dc=1.8 type=dc
