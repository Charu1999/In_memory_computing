// Design: sram_6t/sram_cell_noise_margin
simulator lang=spectre
global 0
parameters x=0
include "/home/ecegrid/a/559mg23/vlsi_assignment/sram_6t/tsmc18dN.m"
include "/home/ecegrid/a/559mg23/vlsi_assignment/sram_6t/tsmc18dP.m"

// sram_6t/sram_cell_noise_margin/schematic
N4 (BLB WL Qbar GND) tsmc18dN w=270.0n l=180.0n m=1 region=sat
N3 (Q WL BL GND) tsmc18dN w=270.0n l=180.0n m=1 region=sat
N2 (Qbar Q GND GND) tsmc18dN w=315.00n l=180.0n m=1 region=sat
N1 (GND Qbar Q GND) tsmc18dN w=315.00n l=180.0n m=1 region=sat
P1 (Q Qbar VDD VDD) tsmc18dP w=810.0n l=180.0n m=1 region=sat
P0 (Qbar Q VDD VDD) tsmc18dP w=810.0n l=180.0n m=1 region=sat
C2 (WL GND) capacitor c=1p m=1
C1 (BLB GND) capacitor c=1p m=1
C0 (BL GND) capacitor c=1p m=1
V0 (Q GND) vsource type=dc dc=x
include "./_graphical_stimuli.scs"
simulatorOptions options temp=27
dcOp dc
dc dc param=x start=0 stop=1.8
save Q Qbar
